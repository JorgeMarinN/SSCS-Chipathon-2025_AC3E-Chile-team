** sch_path: /foss/designs/SSCS-Chipathon-2025_AC3E-Chile-team/xschem/vco/vco_inv_forlvs.sch
.subckt vco_inv_forlvs VDD VSS VIN VOUT VBP VBN
*.PININFO VDD:B VSS:B VIN:I VOUT:O VBP:B VBN:B
MN1 VOUT VIN VSS VBN nfet_05v0 L=5u W=2u nf=1 m=1
MP1 VOUT VIN VDD VBP pfet_05v0 L=5u W=5u nf=1 m=1
.ends
