* Extracted by KLayout with GF180MCU LVS runset on : 09/09/2025 22:14

.SUBCKT vco_invnmosmirr_forlvs VSS VOUT VIN VBP VDD
M$1 VOUT VIN VDD VBP pfet_05v0 L=5U W=5U AS=3.85P AD=3.85P PS=11.54U PD=11.54U
M$2 VOUT VIN \$5 VSS nfet_05v0 L=5U W=2U AS=1.46P AD=1.46P PS=5.46U PD=5.46U
M$3 VSS \$3 \$3 VSS nfet_05v0 L=0.7U W=7U AS=2.29P AD=1.82P PS=12.58U PD=10.64U
M$10 \$5 \$3 VSS VSS nfet_05v0 L=0.7U W=4U AS=1.04P AD=1.04P PS=6.08U PD=6.08U
M$14 \$6 \$3 VSS VSS nfet_05v0 L=0.7U W=7U AS=1.82P AD=2.29P PS=10.64U PD=12.58U
.ENDS vco_invnmosmirr_forlvs
