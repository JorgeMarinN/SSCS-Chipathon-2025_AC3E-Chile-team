* Extracted by KLayout with GF180MCU LVS runset on : 09/09/2025 22:09

.SUBCKT vco_inv-nmosmirr_forlvs
M$1 VOUT VIN VDD VBP pfet_05v0 L=5U W=5U AS=3.85P AD=3.85P PS=11.54U PD=11.54U
M$2 VOUT VIN \$5 VSS nfet_05v0 L=5U W=2U AS=1.46P AD=1.46P PS=5.46U PD=5.46U
M$3 VSS \$3 \$3 VSS nfet_05v0 L=0.7U W=1U AS=0.73P AD=0.26P PS=3.46U PD=1.52U
M$4 \$3 \$3 VSS VSS nfet_05v0 L=0.7U W=1U AS=0.26P AD=0.26P PS=1.52U PD=1.52U
M$5 VSS \$3 \$3 VSS nfet_05v0 L=0.7U W=1U AS=0.26P AD=0.26P PS=1.52U PD=1.52U
M$6 \$3 \$3 VSS VSS nfet_05v0 L=0.7U W=1U AS=0.26P AD=0.26P PS=1.52U PD=1.52U
M$7 VSS \$3 \$3 VSS nfet_05v0 L=0.7U W=1U AS=0.26P AD=0.26P PS=1.52U PD=1.52U
M$8 \$3 \$3 VSS VSS nfet_05v0 L=0.7U W=1U AS=0.26P AD=0.26P PS=1.52U PD=1.52U
M$9 VSS \$3 \$3 VSS nfet_05v0 L=0.7U W=1U AS=0.26P AD=0.26P PS=1.52U PD=1.52U
M$10 \$5 \$3 VSS VSS nfet_05v0 L=0.7U W=1U AS=0.26P AD=0.26P PS=1.52U PD=1.52U
M$11 VSS \$3 \$5 VSS nfet_05v0 L=0.7U W=1U AS=0.26P AD=0.26P PS=1.52U PD=1.52U
M$12 \$5 \$3 VSS VSS nfet_05v0 L=0.7U W=1U AS=0.26P AD=0.26P PS=1.52U PD=1.52U
M$13 VSS \$3 \$5 VSS nfet_05v0 L=0.7U W=1U AS=0.26P AD=0.26P PS=1.52U PD=1.52U
M$14 \$6 \$3 VSS VSS nfet_05v0 L=0.7U W=1U AS=0.26P AD=0.26P PS=1.52U PD=1.52U
M$15 VSS \$3 \$6 VSS nfet_05v0 L=0.7U W=1U AS=0.26P AD=0.26P PS=1.52U PD=1.52U
M$16 \$6 \$3 VSS VSS nfet_05v0 L=0.7U W=1U AS=0.26P AD=0.26P PS=1.52U PD=1.52U
M$17 VSS \$3 \$6 VSS nfet_05v0 L=0.7U W=1U AS=0.26P AD=0.26P PS=1.52U PD=1.52U
M$18 \$6 \$3 VSS VSS nfet_05v0 L=0.7U W=1U AS=0.26P AD=0.26P PS=1.52U PD=1.52U
M$19 VSS \$3 \$6 VSS nfet_05v0 L=0.7U W=1U AS=0.26P AD=0.26P PS=1.52U PD=1.52U
M$20 \$6 \$3 VSS VSS nfet_05v0 L=0.7U W=1U AS=0.26P AD=0.73P PS=1.52U PD=3.46U
.ENDS vco_inv-nmosmirr_forlvs
