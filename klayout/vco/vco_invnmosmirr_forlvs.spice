** sch_path: /foss/designs/SSCS-Chipathon-2025_AC3E-Chile-team/xschem/vco/vco_invnmosmirr_forlvs.sch
.subckt vco_invnmosmirr_forlvs VSS VDD1 VDD2 VDD VIN VOUT VBP
*.PININFO VSS:B VDD1:B VDD2:B VDD:B VIN:I VOUT:O VBP:B
MN2 VDD1 VDD1 VSS VSS nfet_05v0 L=0.70u W=7u nf=7 m=1
MN3 VDD2 VDD1 VSS VSS nfet_05v0 L=0.70u W=7u nf=7 m=1
MN4 net1 VDD1 VSS VSS nfet_05v0 L=0.70u W=4u nf=4 m=1
MN1 VOUT VIN net1 VSS nfet_05v0 L=5u W=2u nf=1 m=1
MP1 VOUT VIN VDD VBP pfet_05v0 L=5u W=5u nf=1 m=1
.ends
