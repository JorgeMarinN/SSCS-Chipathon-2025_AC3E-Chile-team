* Extracted by KLayout with GF180MCU LVS runset on : 09/09/2025 21:03

.SUBCKT vco_inv_forlvs VBN VBP VSS VOUT VIN VDD
M$1 VOUT VIN VDD VBP pfet_05v0 L=5U W=5U AS=3.85P AD=3.85P PS=11.54U PD=11.54U
M$2 VOUT VIN VSS VBN nfet_05v0 L=5U W=2U AS=1.46P AD=1.46P PS=5.46U PD=5.46U
.ENDS vco_inv_forlvs
