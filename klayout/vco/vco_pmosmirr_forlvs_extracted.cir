* Extracted by KLayout with GF180MCU LVS runset on : 11/09/2025 15:00

.SUBCKT vco_pmosmirr_forlvs VSS2 VDD VSS1
M$1 VSS1 VSS1 VDD VSS1 nfet_05v0 L=4U W=1U AS=0.73P AD=0.26P PS=3.46U PD=1.52U
M$2 \$5 VSS1 VSS1 VSS1 nfet_05v0 L=4U W=2U AS=0.52P AD=0.52P PS=3.04U PD=3.04U
M$4 \$6 VSS1 VSS1 VSS1 nfet_05v0 L=4U W=2U AS=0.52P AD=0.52P PS=3.04U PD=3.04U
M$6 \$7 VSS1 VSS1 VSS1 nfet_05v0 L=4U W=2U AS=0.52P AD=0.52P PS=3.04U PD=3.04U
M$8 \$8 VSS1 VSS1 VSS1 nfet_05v0 L=4U W=1U AS=0.26P AD=0.26P PS=1.52U PD=1.52U
M$9 VSS2 VSS1 \$8 VSS1 nfet_05v0 L=4U W=1U AS=0.26P AD=0.26P PS=1.52U PD=1.52U
M$10 \$9 VSS1 VSS2 VSS1 nfet_05v0 L=4U W=2U AS=0.52P AD=0.52P PS=3.04U PD=3.04U
M$12 \$10 VSS1 VSS2 VSS1 nfet_05v0 L=4U W=2U AS=0.52P AD=0.99P PS=3.04U PD=4.98U
.ENDS vco_pmosmirr_forlvs
